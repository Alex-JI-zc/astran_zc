.subckt SQRT_COMPLEX17_06W GND VCC Y a b c
M0 Y INVY VCC VCC PMOS_VTL W=0.3u L=0.05u
+ ad=0p pd=0u as=0p ps=0u
M1 INVY b pN2 VCC PMOS_VTL W=0.6u L=0.05u
+ ad=0p pd=0u as=0p ps=0u
M2 INVY c pN1 VCC PMOS_VTL W=0.6u L=0.05u
+ ad=0p pd=0u as=0p ps=0u
M3 pN2 a VCC VCC PMOS_VTL W=0.6u L=0.05u
+ ad=0p pd=0u as=0p ps=0u
M4 pN1 b VCC VCC PMOS_VTL W=0.6u L=0.05u
+ ad=0p pd=0u as=0p ps=0u
M5 pN1 a VCC VCC PMOS_VTL W=0.6u L=0.05u
+ ad=0p pd=0u as=0p ps=0u
M6 nN1 a GND GND NMOS_VTL W=0.3u L=0.05u
+ ad=0p pd=0u as=0p ps=0u
M7 INVY b nN2 GND NMOS_VTL W=0.3u L=0.05u
+ ad=0p pd=0u as=0p ps=0u
M8 INVY c nN1 GND NMOS_VTL W=0.3u L=0.05u
+ ad=0p pd=0u as=0p ps=0u
M9 nN2 a GND GND NMOS_VTL W=0.3u L=0.05u
+ ad=0p pd=0u as=0p ps=0u
M10 nN1 b GND GND NMOS_VTL W=0.3u L=0.05u
+ ad=0p pd=0u as=0p ps=0u
M11 Y INVY GND GND NMOS_VTL W=0.15u L=0.05u
+ ad=0p pd=0u as=0p ps=0u
.ends SQRT_COMPLEX17_06W
