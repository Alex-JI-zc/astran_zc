.subckt VOTER_COMPLEX4_06W GND VCC Y a b c d e f
M0 Y e pN2 VCC PMOS_VTL W=0.6u L=0.05u
+ ad=0p pd=0u as=0p ps=0u
M1 pN1 b VCC VCC PMOS_VTL W=0.6u L=0.05u
+ ad=0p pd=0u as=0p ps=0u
M2 pN1 a VCC VCC PMOS_VTL W=0.6u L=0.05u
+ ad=0p pd=0u as=0p ps=0u
M3 Y c pN1 VCC PMOS_VTL W=0.6u L=0.05u
+ ad=0p pd=0u as=0p ps=0u
M4 Y d pN2 VCC PMOS_VTL W=0.6u L=0.05u
+ ad=0p pd=0u as=0p ps=0u
M5 pN2 f VCC VCC PMOS_VTL W=0.6u L=0.05u
+ ad=0p pd=0u as=0p ps=0u
M6 nN2 a nN1 GND NMOS_VTL W=0.6u L=0.05u
+ ad=0p pd=0u as=0p ps=0u
M7 nN1 f GND GND NMOS_VTL W=0.45u L=0.05u
+ ad=0p pd=0u as=0p ps=0u
M8 Y b nN2 GND NMOS_VTL W=0.6u L=0.05u
+ ad=0p pd=0u as=0p ps=0u
M9 nN3 d GND GND NMOS_VTL W=0.6u L=0.05u
+ ad=0p pd=0u as=0p ps=0u
M10 nN1 e nN3 GND NMOS_VTL W=0.6u L=0.05u
+ ad=0p pd=0u as=0p ps=0u
M11 Y c nN1 GND NMOS_VTL W=0.45u L=0.05u
+ ad=0p pd=0u as=0p ps=0u
.ends VOTER_COMPLEX4_06W
