.subckt INT2FLOAT_COMPLEX2_06W GND VCC Y a b c d e f g h
M0 Y INVY VCC VCC PMOS_VTL W=0.3u L=0.05u
+ ad=0p pd=0u as=0p ps=0u
M1 INVY b pN2 VCC PMOS_VTL W=1.2u L=0.05u
+ ad=0p pd=0u as=0p ps=0u
M2 pN2 c pN3 VCC PMOS_VTL W=1.2u L=0.05u
+ ad=0p pd=0u as=0p ps=0u
M3 INVY d pN4 VCC PMOS_VTL W=1.2u L=0.05u
+ ad=0p pd=0u as=0p ps=0u
M4 pN4 e pN3 VCC PMOS_VTL W=1.2u L=0.05u
+ ad=0p pd=0u as=0p ps=0u
M5 INVY f pN3 VCC PMOS_VTL W=0.9u L=0.05u
+ ad=0p pd=0u as=0p ps=0u
M6 pN1 g VCC VCC PMOS_VTL W=1.2u L=0.05u
+ ad=0p pd=0u as=0p ps=0u
M7 pN3 h pN1 VCC PMOS_VTL W=1.2u L=0.05u
+ ad=0p pd=0u as=0p ps=0u
M8 INVY a pN2 VCC PMOS_VTL W=1.2u L=0.05u
+ ad=0p pd=0u as=0p ps=0u
M9 nN1 a nN2 GND NMOS_VTL W=0.6u L=0.05u
+ ad=0p pd=0u as=0p ps=0u
M10 nN2 b GND GND NMOS_VTL W=0.6u L=0.05u
+ ad=0p pd=0u as=0p ps=0u
M11 nN1 c GND GND NMOS_VTL W=0.45u L=0.05u
+ ad=0p pd=0u as=0p ps=0u
M12 INVY d nN3 GND NMOS_VTL W=0.6u L=0.05u
+ ad=0p pd=0u as=0p ps=0u
M13 INVY e nN3 GND NMOS_VTL W=0.6u L=0.05u
+ ad=0p pd=0u as=0p ps=0u
M14 nN3 f nN1 GND NMOS_VTL W=0.6u L=0.05u
+ ad=0p pd=0u as=0p ps=0u
M15 INVY g GND GND NMOS_VTL W=0.15u L=0.05u
+ ad=0p pd=0u as=0p ps=0u
M16 INVY h GND GND NMOS_VTL W=0.15u L=0.05u
+ ad=0p pd=0u as=0p ps=0u
M17 Y INVY GND GND NMOS_VTL W=0.15u L=0.05u
+ ad=0p pd=0u as=0p ps=0u
.ends INT2FLOAT_COMPLEX2_06W
