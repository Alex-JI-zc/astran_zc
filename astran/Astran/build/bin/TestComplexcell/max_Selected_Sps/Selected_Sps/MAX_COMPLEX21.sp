.subckt MAX_COMPLEX21 GND VCC Y a b c d e
M0 Y !a pN1 VCC PMOS W=1u L=0.05u
+ ad=0p pd=0u as=0p ps=0u
M1 pN1 c VCC VCC PMOS W=1u L=0.05u
+ ad=0p pd=0u as=0p ps=0u
M2 Y d pN2 VCC PMOS W=1u L=0.05u
+ ad=0p pd=0u as=0p ps=0u
M3 Y e VCC VCC PMOS W=0.5u L=0.05u
+ ad=0p pd=0u as=0p ps=0u
M4 pN2 !b VCC VCC PMOS W=1u L=0.05u
+ ad=0p pd=0u as=0p ps=0u
M5 !a a VCC VCC PMOS W=0.5u L=0.05u
+ ad=0p pd=0u as=0p ps=0u
M6 !b b VCC VCC PMOS W=0.5u L=0.05u
+ ad=0p pd=0u as=0p ps=0u
M7 nN2 c nN1 GND NMOS W=0.75u L=0.05u
+ ad=0p pd=0u as=0p ps=0u
M8 nN1 d GND GND NMOS W=0.75u L=0.05u
+ ad=0p pd=0u as=0p ps=0u
M9 !b b GND GND NMOS W=0.25u L=0.05u
+ ad=0p pd=0u as=0p ps=0u
M10 nN2 !a nN1 GND NMOS W=0.75u L=0.05u
+ ad=0p pd=0u as=0p ps=0u
M11 nN1 !b GND GND NMOS W=0.75u L=0.05u
+ ad=0p pd=0u as=0p ps=0u
M12 !a a GND GND NMOS W=0.25u L=0.05u
+ ad=0p pd=0u as=0p ps=0u
M13 Y e nN2 GND NMOS W=0.75u L=0.05u
+ ad=0p pd=0u as=0p ps=0u
.ends MAX_COMPLEX21
