.subckt MAX_COMPLEX1_06W GND VCC Y a b c d e f
M0 Y !a pN1 VCC PMOS_VTL W=0.6u L=0.05u
+ ad=0p pd=0u as=0p ps=0u
M1 pN1 c VCC VCC PMOS_VTL W=0.6u L=0.05u
+ ad=0p pd=0u as=0p ps=0u
M2 Y d pN3 VCC PMOS_VTL W=0.6u L=0.05u
+ ad=0p pd=0u as=0p ps=0u
M3 pN2 f VCC VCC PMOS_VTL W=0.6u L=0.05u
+ ad=0p pd=0u as=0p ps=0u
M4 Y e pN2 VCC PMOS_VTL W=0.6u L=0.05u
+ ad=0p pd=0u as=0p ps=0u
M5 pN3 !b VCC VCC PMOS_VTL W=0.6u L=0.05u
+ ad=0p pd=0u as=0p ps=0u
M6 !a a VCC VCC PMOS_VTL W=0.3u L=0.05u
+ ad=0p pd=0u as=0p ps=0u
M7 !b b VCC VCC PMOS_VTL W=0.3u L=0.05u
+ ad=0p pd=0u as=0p ps=0u
M8 nN1 c GND GND NMOS_VTL W=0.45u L=0.05u
+ ad=0p pd=0u as=0p ps=0u
M9 nN2 d nN1 GND NMOS_VTL W=0.45u L=0.05u
+ ad=0p pd=0u as=0p ps=0u
M10 !b b GND GND NMOS_VTL W=0.15u L=0.05u
+ ad=0p pd=0u as=0p ps=0u
M11 Y e nN2 GND NMOS_VTL W=0.45u L=0.05u
+ ad=0p pd=0u as=0p ps=0u
M12 nN1 !a GND GND NMOS_VTL W=0.45u L=0.05u
+ ad=0p pd=0u as=0p ps=0u
M13 nN2 !b nN1 GND NMOS_VTL W=0.45u L=0.05u
+ ad=0p pd=0u as=0p ps=0u
M14 !a a GND GND NMOS_VTL W=0.15u L=0.05u
+ ad=0p pd=0u as=0p ps=0u
M15 Y f nN2 GND NMOS_VTL W=0.45u L=0.05u
+ ad=0p pd=0u as=0p ps=0u
.ends MAX_COMPLEX1_06W
