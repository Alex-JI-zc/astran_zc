.subckt SIN_COMPLEX5 GND VCC Y a b c d e f
M0 Y !f pN3 VCC PMOS W=1u L=0.05u
+ ad=0p pd=0u as=0p ps=0u
M1 pN1 a VCC VCC PMOS W=1u L=0.05u
+ ad=0p pd=0u as=0p ps=0u
M2 Y b pN2 VCC PMOS W=1u L=0.05u
+ ad=0p pd=0u as=0p ps=0u
M3 pN4 d VCC VCC PMOS W=1u L=0.05u
+ ad=0p pd=0u as=0p ps=0u
M4 pN3 e VCC VCC PMOS W=1u L=0.05u
+ ad=0p pd=0u as=0p ps=0u
M5 Y c pN1 VCC PMOS W=1u L=0.05u
+ ad=0p pd=0u as=0p ps=0u
M6 pN2 !c VCC VCC PMOS W=1u L=0.05u
+ ad=0p pd=0u as=0p ps=0u
M7 Y f pN4 VCC PMOS W=1u L=0.05u
+ ad=0p pd=0u as=0p ps=0u
M8 !c c VCC VCC PMOS W=0.5u L=0.05u
+ ad=0p pd=0u as=0p ps=0u
M9 !f f VCC VCC PMOS W=0.5u L=0.05u
+ ad=0p pd=0u as=0p ps=0u
M10 nN1 a nN2 GND NMOS W=1u L=0.05u
+ ad=0p pd=0u as=0p ps=0u
M11 !f f GND GND NMOS W=0.25u L=0.05u
+ ad=0p pd=0u as=0p ps=0u
M12 nN1 c nN2 GND NMOS W=1u L=0.05u
+ ad=0p pd=0u as=0p ps=0u
M13 nN2 d GND GND NMOS W=1u L=0.05u
+ ad=0p pd=0u as=0p ps=0u
M14 nN3 e nN1 GND NMOS W=1u L=0.05u
+ ad=0p pd=0u as=0p ps=0u
M15 nN2 f GND GND NMOS W=1u L=0.05u
+ ad=0p pd=0u as=0p ps=0u
M16 Y b nN3 GND NMOS W=1u L=0.05u
+ ad=0p pd=0u as=0p ps=0u
M17 nN3 !f nN1 GND NMOS W=1u L=0.05u
+ ad=0p pd=0u as=0p ps=0u
M18 !c c GND GND NMOS W=0.25u L=0.05u
+ ad=0p pd=0u as=0p ps=0u
M19 Y !c nN3 GND NMOS W=1u L=0.05u
+ ad=0p pd=0u as=0p ps=0u
.ends SIN_COMPLEX5
