.subckt I2C_COMPLEX3 GND VCC Y a b c d
M0 Y d pN1 VCC PMOS W=1.5u L=0.05u
+ ad=0p pd=0u as=0p ps=0u
M1 pN2 b VCC VCC PMOS W=1.5u L=0.05u
+ ad=0p pd=0u as=0p ps=0u
M2 pN1 a pN2 VCC PMOS W=1.5u L=0.05u
+ ad=0p pd=0u as=0p ps=0u
M3 Y c pN1 VCC PMOS W=1.5u L=0.05u
+ ad=0p pd=0u as=0p ps=0u
M4 pN2 !d VCC VCC PMOS W=1.5u L=0.05u
+ ad=0p pd=0u as=0p ps=0u
M5 !d d VCC VCC PMOS W=0.5u L=0.05u
+ ad=0p pd=0u as=0p ps=0u
M6 !d d GND GND NMOS W=0.25u L=0.05u
+ ad=0p pd=0u as=0p ps=0u
M7 Y a GND GND NMOS W=0.25u L=0.05u
+ ad=0p pd=0u as=0p ps=0u
M8 Y b nN2 GND NMOS W=0.5u L=0.05u
+ ad=0p pd=0u as=0p ps=0u
M9 nN1 d GND GND NMOS W=0.5u L=0.05u
+ ad=0p pd=0u as=0p ps=0u
M10 nN2 !d GND GND NMOS W=0.5u L=0.05u
+ ad=0p pd=0u as=0p ps=0u
M11 Y c nN1 GND NMOS W=0.5u L=0.05u
+ ad=0p pd=0u as=0p ps=0u
.ends I2C_COMPLEX3
