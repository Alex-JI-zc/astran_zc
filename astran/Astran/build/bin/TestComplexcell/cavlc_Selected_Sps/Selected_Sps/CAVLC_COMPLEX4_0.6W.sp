.subckt CAVLC_COMPLEX4_06W GND VCC Y a b c d e f g
M0 Y INVY VCC VCC PMOS_VTL W=0.3u L=0.05u
+ ad=0p pd=0u as=0p ps=0u
M1 INVY b pN1 VCC PMOS_VTL W=0.6u L=0.05u
+ ad=0p pd=0u as=0p ps=0u
M2 INVY c pN1 VCC PMOS_VTL W=0.6u L=0.05u
+ ad=0p pd=0u as=0p ps=0u
M3 INVY d pN1 VCC PMOS_VTL W=0.6u L=0.05u
+ ad=0p pd=0u as=0p ps=0u
M4 pN1 e VCC VCC PMOS_VTL W=0.6u L=0.05u
+ ad=0p pd=0u as=0p ps=0u
M5 pN1 f VCC VCC PMOS_VTL W=0.6u L=0.05u
+ ad=0p pd=0u as=0p ps=0u
M6 pN1 g VCC VCC PMOS_VTL W=0.6u L=0.05u
+ ad=0p pd=0u as=0p ps=0u
M7 INVY a pN1 VCC PMOS_VTL W=0.6u L=0.05u
+ ad=0p pd=0u as=0p ps=0u
M8 nN1 a nN2 GND NMOS_VTL W=0.6u L=0.05u
+ ad=0p pd=0u as=0p ps=0u
M9 INVY b nN3 GND NMOS_VTL W=0.6u L=0.05u
+ ad=0p pd=0u as=0p ps=0u
M10 nN3 c nN1 GND NMOS_VTL W=0.6u L=0.05u
+ ad=0p pd=0u as=0p ps=0u
M11 nN2 d GND GND NMOS_VTL W=0.6u L=0.05u
+ ad=0p pd=0u as=0p ps=0u
M12 nN5 e GND GND NMOS_VTL W=0.45u L=0.05u
+ ad=0p pd=0u as=0p ps=0u
M13 INVY f nN4 GND NMOS_VTL W=0.45u L=0.05u
+ ad=0p pd=0u as=0p ps=0u
M14 nN4 g nN5 GND NMOS_VTL W=0.45u L=0.05u
+ ad=0p pd=0u as=0p ps=0u
M15 Y INVY GND GND NMOS_VTL W=0.15u L=0.05u
+ ad=0p pd=0u as=0p ps=0u
.ends CAVLC_COMPLEX4_06W
