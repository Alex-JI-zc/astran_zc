.subckt BAR_COMPLEX2 GND VCC Y a b c d e f g h
M0 Y d pN3 VCC PMOS W=2u L=0.05u
+ ad=0p pd=0u as=0p ps=0u
M1 pN1 b pN2 VCC PMOS W=2u L=0.05u
+ ad=0p pd=0u as=0p ps=0u
M2 pN1 a pN2 VCC PMOS W=2u L=0.05u
+ ad=0p pd=0u as=0p ps=0u
M3 Y c pN3 VCC PMOS W=2u L=0.05u
+ ad=0p pd=0u as=0p ps=0u
M4 pN3 e pN1 VCC PMOS W=2u L=0.05u
+ ad=0p pd=0u as=0p ps=0u
M5 pN3 f pN1 VCC PMOS W=2u L=0.05u
+ ad=0p pd=0u as=0p ps=0u
M6 pN2 g VCC VCC PMOS W=2u L=0.05u
+ ad=0p pd=0u as=0p ps=0u
M7 pN2 h VCC VCC PMOS W=2u L=0.05u
+ ad=0p pd=0u as=0p ps=0u
M8 nN1 h GND GND NMOS W=0.5u L=0.05u
+ ad=0p pd=0u as=0p ps=0u
M9 nN2 b GND GND NMOS W=0.5u L=0.05u
+ ad=0p pd=0u as=0p ps=0u
M10 nN3 c GND GND NMOS W=0.5u L=0.05u
+ ad=0p pd=0u as=0p ps=0u
M11 Y a nN2 GND NMOS W=0.5u L=0.05u
+ ad=0p pd=0u as=0p ps=0u
M12 Y d nN3 GND NMOS W=0.5u L=0.05u
+ ad=0p pd=0u as=0p ps=0u
M13 nN4 f GND GND NMOS W=0.5u L=0.05u
+ ad=0p pd=0u as=0p ps=0u
M14 Y e nN4 GND NMOS W=0.5u L=0.05u
+ ad=0p pd=0u as=0p ps=0u
M15 Y g nN1 GND NMOS W=0.5u L=0.05u
+ ad=0p pd=0u as=0p ps=0u
.ends BAR_COMPLEX2
