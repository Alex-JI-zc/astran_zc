.subckt SQUARE_COMPLEX0 GND VCC Y a b c d
M0 Y d VCC VCC PMOS W=0.5u L=0.05u
+ ad=0p pd=0u as=0p ps=0u
M1 Y a VCC VCC PMOS W=0.5u L=0.05u
+ ad=0p pd=0u as=0p ps=0u
M2 Y b VCC VCC PMOS W=0.5u L=0.05u
+ ad=0p pd=0u as=0p ps=0u
M3 Y c VCC VCC PMOS W=0.5u L=0.05u
+ ad=0p pd=0u as=0p ps=0u
M4 nN2 d nN3 GND NMOS W=1u L=0.05u
+ ad=0p pd=0u as=0p ps=0u
M5 nN3 b GND GND NMOS W=1u L=0.05u
+ ad=0p pd=0u as=0p ps=0u
M6 nN1 c nN2 GND NMOS W=1u L=0.05u
+ ad=0p pd=0u as=0p ps=0u
M7 Y a nN1 GND NMOS W=1u L=0.05u
+ ad=0p pd=0u as=0p ps=0u
.ends SQUARE_COMPLEX0
