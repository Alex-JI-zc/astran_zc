.subckt div_COMPLEX8 GND VCC Y a b c
M0 Y c pN1 VCC PMOS W=1u L=0.05u
+ ad=0p pd=0u as=0p ps=0u
M1 pN1 a VCC VCC PMOS W=1u L=0.05u
+ ad=0p pd=0u as=0p ps=0u
M2 Y b pN2 VCC PMOS W=1u L=0.05u
+ ad=0p pd=0u as=0p ps=0u
M3 pN2 !c VCC VCC PMOS W=1u L=0.05u
+ ad=0p pd=0u as=0p ps=0u
M4 !c c VCC VCC PMOS W=0.5u L=0.05u
+ ad=0p pd=0u as=0p ps=0u
M5 !c c GND GND NMOS W=0.25u L=0.05u
+ ad=0p pd=0u as=0p ps=0u
M6 Y a nN1 GND NMOS W=0.5u L=0.05u
+ ad=0p pd=0u as=0p ps=0u
M7 nN2 c GND GND NMOS W=0.5u L=0.05u
+ ad=0p pd=0u as=0p ps=0u
M8 nN1 !c GND GND NMOS W=0.5u L=0.05u
+ ad=0p pd=0u as=0p ps=0u
M9 Y b nN2 GND NMOS W=0.5u L=0.05u
+ ad=0p pd=0u as=0p ps=0u
.ends div_COMPLEX8
