.subckt hyp_COMPLEX11 GND VCC Y a b c d
M0 Y !c pN4 VCC PMOS W=2u L=0.05u
+ ad=0p pd=0u as=0p ps=0u
M1 pN2 b pN3 VCC PMOS W=2u L=0.05u
+ ad=0p pd=0u as=0p ps=0u
M2 pN1 a pN2 VCC PMOS W=2u L=0.05u
+ ad=0p pd=0u as=0p ps=0u
M3 pN5 d VCC VCC PMOS W=2u L=0.05u
+ ad=0p pd=0u as=0p ps=0u
M4 pN1 !a pN6 VCC PMOS W=2u L=0.05u
+ ad=0p pd=0u as=0p ps=0u
M5 pN6 !b pN3 VCC PMOS W=2u L=0.05u
+ ad=0p pd=0u as=0p ps=0u
M6 Y c pN1 VCC PMOS W=2u L=0.05u
+ ad=0p pd=0u as=0p ps=0u
M7 pN3 !d VCC VCC PMOS W=2u L=0.05u
+ ad=0p pd=0u as=0p ps=0u
M8 pN4 a pN6 VCC PMOS W=2u L=0.05u
+ ad=0p pd=0u as=0p ps=0u
M9 pN6 b pN5 VCC PMOS W=2u L=0.05u
+ ad=0p pd=0u as=0p ps=0u
M10 pN4 !a pN2 VCC PMOS W=2u L=0.05u
+ ad=0p pd=0u as=0p ps=0u
M11 pN2 !b pN5 VCC PMOS W=2u L=0.05u
+ ad=0p pd=0u as=0p ps=0u
M12 !a a VCC VCC PMOS W=0.5u L=0.05u
+ ad=0p pd=0u as=0p ps=0u
M13 !b b VCC VCC PMOS W=0.5u L=0.05u
+ ad=0p pd=0u as=0p ps=0u
M14 !c c VCC VCC PMOS W=0.5u L=0.05u
+ ad=0p pd=0u as=0p ps=0u
M15 !d d VCC VCC PMOS W=0.5u L=0.05u
+ ad=0p pd=0u as=0p ps=0u
M16 !d d GND GND NMOS W=0.25u L=0.05u
+ ad=0p pd=0u as=0p ps=0u
M17 nN4 b nN3 GND NMOS W=1u L=0.05u
+ ad=0p pd=0u as=0p ps=0u
M18 nN2 c nN5 GND NMOS W=1u L=0.05u
+ ad=0p pd=0u as=0p ps=0u
M19 nN4 d GND GND NMOS W=1u L=0.05u
+ ad=0p pd=0u as=0p ps=0u
M20 nN1 !a GND GND NMOS W=1u L=0.05u
+ ad=0p pd=0u as=0p ps=0u
M21 nN4 !b nN2 GND NMOS W=1u L=0.05u
+ ad=0p pd=0u as=0p ps=0u
M22 nN2 !c nN1 GND NMOS W=1u L=0.05u
+ ad=0p pd=0u as=0p ps=0u
M23 Y a nN1 GND NMOS W=1u L=0.05u
+ ad=0p pd=0u as=0p ps=0u
M24 nN3 c nN1 GND NMOS W=1u L=0.05u
+ ad=0p pd=0u as=0p ps=0u
M25 Y !d nN4 GND NMOS W=1u L=0.05u
+ ad=0p pd=0u as=0p ps=0u
M26 nN5 !c nN3 GND NMOS W=1u L=0.05u
+ ad=0p pd=0u as=0p ps=0u
M27 nN5 a GND GND NMOS W=1u L=0.05u
+ ad=0p pd=0u as=0p ps=0u
M28 !a a GND GND NMOS W=0.25u L=0.05u
+ ad=0p pd=0u as=0p ps=0u
M29 !b b GND GND NMOS W=0.25u L=0.05u
+ ad=0p pd=0u as=0p ps=0u
M30 !c c GND GND NMOS W=0.25u L=0.05u
+ ad=0p pd=0u as=0p ps=0u
M31 Y !a nN5 GND NMOS W=1u L=0.05u
+ ad=0p pd=0u as=0p ps=0u
.ends hyp_COMPLEX11
