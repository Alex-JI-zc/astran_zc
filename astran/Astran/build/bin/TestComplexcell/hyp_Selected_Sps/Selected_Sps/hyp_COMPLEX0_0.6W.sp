.subckt HYP_COMPLEX0_06W GND VCC Y a b c d
M0 Y INVY VCC VCC PMOS_VTL W=0.3u L=0.05u
+ ad=0p pd=0u as=0p ps=0u
M1 INVY b pN1 VCC PMOS_VTL W=0.6u L=0.05u
+ ad=0p pd=0u as=0p ps=0u
M2 INVY c pN2 VCC PMOS_VTL W=0.6u L=0.05u
+ ad=0p pd=0u as=0p ps=0u
M3 pN2 d VCC VCC PMOS_VTL W=0.6u L=0.05u
+ ad=0p pd=0u as=0p ps=0u
M4 pN1 a VCC VCC PMOS_VTL W=0.6u L=0.05u
+ ad=0p pd=0u as=0p ps=0u
M5 INVY a nN1 GND NMOS_VTL W=0.3u L=0.05u
+ ad=0p pd=0u as=0p ps=0u
M6 INVY b nN1 GND NMOS_VTL W=0.3u L=0.05u
+ ad=0p pd=0u as=0p ps=0u
M7 nN1 c GND GND NMOS_VTL W=0.3u L=0.05u
+ ad=0p pd=0u as=0p ps=0u
M8 nN1 d GND GND NMOS_VTL W=0.3u L=0.05u
+ ad=0p pd=0u as=0p ps=0u
M9 Y INVY GND GND NMOS_VTL W=0.15u L=0.05u
+ ad=0p pd=0u as=0p ps=0u
.ends HYP_COMPLEX0_06W
