.subckt hyp_COMPLEX0 GND VCC Y a b c d
M0 Y INVY VCC VCC PMOS W=0.5u L=0.05u
+ ad=0p pd=0u as=0p ps=0u
M1 INVY b pN1 VCC PMOS W=1u L=0.05u
+ ad=0p pd=0u as=0p ps=0u
M2 INVY c pN2 VCC PMOS W=1u L=0.05u
+ ad=0p pd=0u as=0p ps=0u
M3 pN2 d VCC VCC PMOS W=1u L=0.05u
+ ad=0p pd=0u as=0p ps=0u
M4 pN1 a VCC VCC PMOS W=1u L=0.05u
+ ad=0p pd=0u as=0p ps=0u
M5 INVY a nN1 GND NMOS W=0.5u L=0.05u
+ ad=0p pd=0u as=0p ps=0u
M6 INVY b nN1 GND NMOS W=0.5u L=0.05u
+ ad=0p pd=0u as=0p ps=0u
M7 nN1 c GND GND NMOS W=0.5u L=0.05u
+ ad=0p pd=0u as=0p ps=0u
M8 nN1 d GND GND NMOS W=0.5u L=0.05u
+ ad=0p pd=0u as=0p ps=0u
M9 Y INVY GND GND NMOS W=0.25u L=0.05u
+ ad=0p pd=0u as=0p ps=0u
.ends hyp_COMPLEX0
