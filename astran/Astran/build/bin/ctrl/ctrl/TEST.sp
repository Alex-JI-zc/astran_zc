.subckt Test GND VCC Y a b c d
M0 Y INVY VCC VCC PMOS W=0.5u L=0.05u
+ ad=0p pd=0u as=0p ps=0u
M1 INVY c VCC VCC PMOS W=0.5u L=0.05u
+ ad=0p pd=0u as=0p ps=0u
M2 INVY d VCC VCC PMOS W=0.5u L=0.05u
+ ad=0p pd=0u as=0p ps=0u
M3 INVY !b VCC VCC PMOS W=0.5u L=0.05u
+ ad=0p pd=0u as=0p ps=0u
M4 !b b VCC VCC PMOS W=0.5u L=0.05u
+ ad=0p pd=0u as=0p ps=0u
M5 INVY a VCC VCC PMOS W=0.5u L=0.05u
+ ad=0p pd=0u as=0p ps=0u
M6 nN1 a nN2 GND NMOS W=1u L=0.05u
+ ad=0p pd=0u as=0p ps=0u
M7 INVY c nN3 GND NMOS W=1u L=0.05u
+ ad=0p pd=0u as=0p ps=0u
M8 nN3 d nN1 GND NMOS W=1u L=0.05u
+ ad=0p pd=0u as=0p ps=0u
M9 nN2 !b GND GND NMOS W=1u L=0.05u
+ ad=0p pd=0u as=0p ps=0u
M10 !b b GND GND NMOS W=0.25u L=0.05u
+ ad=0p pd=0u as=0p ps=0u
M11 Y INVY GND GND NMOS W=0.25u L=0.05u
+ ad=0p pd=0u as=0p ps=0u
.ends Test
