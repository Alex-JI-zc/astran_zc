.subckt COMPLEX103 cl0#Y cl1#C cl1#Y cl1#A cl1#B cl2#C cl2#A cl2#Y VCC cl2#B GND
Mcl0#0 cl0#a_2_6# cl1#Y VCC VCC PMOS_VTL W=0.5u L=0.05u
+ ad=0p pd=0u as=0p ps=0u
Mcl0#1 VCC cl2#Y cl0#a_2_6# VCC PMOS_VTL W=0.5u L=0.05u
+ ad=0p pd=0u as=0p ps=0u
Mcl0#2 cl0#Y cl0#a_2_6# VCC VCC PMOS_VTL W=0.5u L=0.05u
+ ad=0p pd=0u as=0p ps=0u
Mcl0#3 cl0#a_9_6# cl1#Y cl0#a_2_6# GND NMOS_VTL W=0.5u L=0.05u
+ ad=0p pd=0u as=0p ps=0u
Mcl0#4 GND cl2#Y cl0#a_9_6# GND NMOS_VTL W=0.5u L=0.05u
+ ad=0p pd=0u as=0p ps=0u
Mcl0#5 cl0#Y cl0#a_2_6# GND GND NMOS_VTL W=0.25u L=0.05u
+ ad=0p pd=0u as=0p ps=0u
Mcl1#0 cl1#Y cl1#A VCC VCC PMOS_VTL W=0.5u L=0.05u
+ ad=0p pd=0u as=0p ps=0u
Mcl1#1 VCC cl1#B cl1#Y VCC PMOS_VTL W=0.5u L=0.05u
+ ad=0p pd=0u as=0p ps=0u
Mcl1#2 cl1#Y cl1#C VCC VCC PMOS_VTL W=0.5u L=0.05u
+ ad=0p pd=0u as=0p ps=0u
Mcl1#3 cl1#a_9_6# cl1#A GND GND NMOS_VTL W=0.75u L=0.05u
+ ad=0p pd=0u as=0p ps=0u
Mcl1#4 cl1#a_14_6# cl1#B cl1#a_9_6# GND NMOS_VTL W=0.75u L=0.05u
+ ad=0p pd=0u as=0p ps=0u
Mcl1#5 cl1#Y cl1#C cl1#a_14_6# GND NMOS_VTL W=0.75u L=0.05u
+ ad=0p pd=0u as=0p ps=0u
Mcl2#0 cl2#Y cl2#A VCC VCC PMOS_VTL W=0.5u L=0.05u
+ ad=0p pd=0u as=0p ps=0u
Mcl2#1 VCC cl2#B cl2#Y VCC PMOS_VTL W=0.5u L=0.05u
+ ad=0p pd=0u as=0p ps=0u
Mcl2#2 cl2#Y cl2#C VCC VCC PMOS_VTL W=0.5u L=0.05u
+ ad=0p pd=0u as=0p ps=0u
Mcl2#3 cl2#a_9_6# cl2#A GND GND NMOS_VTL W=0.75u L=0.05u
+ ad=0p pd=0u as=0p ps=0u
Mcl2#4 cl2#a_14_6# cl2#B cl2#a_9_6# GND NMOS_VTL W=0.75u L=0.05u
+ ad=0p pd=0u as=0p ps=0u
Mcl2#5 cl2#Y cl2#C cl2#a_14_6# GND NMOS_VTL W=0.75u L=0.05u
+ ad=0p pd=0u as=0p ps=0u
.ends COMPLEX103
* pattern code: [AND2X1,NAND3X1,NAND3X1]
* 1 occurrences in design
* each contains 3 cells
* Example occurence:
*   .subckt AND2X1 A=$abc$926$new_n69_ B=$abc$926$new_n70_ Y=$abc$926$new_n106_
*   .subckt NAND3X1 A=opcode[0] B=$abc$926$new_n36_ C=opcode[3] Y=$abc$926$new_n69_
*   .subckt NAND3X1 A=opcode[0] B=opcode[1] C=$abc$926$new_n66_ Y=$abc$926$new_n70_
